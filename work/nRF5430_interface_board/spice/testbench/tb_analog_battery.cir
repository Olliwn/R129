* tb_analog_battery.cir
* TESTBENCH 5: Battery Voltage Analog Path
* Verifies the voltage divider + clamp + buffer + RC filter chain
* for the battery monitoring ADC input.
*
* Pass criteria:
*   - ADC input stays within 0-3.3V across full battery range (9-14.4V)
*   - Divider ratio accuracy < 1% of theoretical (2.2/12.2 = 0.1803)
*   - Clamping activates correctly above ~18V input
*   - Step response settles within 1ms

.title TB5: Battery Voltage Analog Path Verification

* === Power Rails ===
V_3v3 v3_bus 0 DC 3.3

* Diode model
.model D_1N4148 D(Is=2.52e-9 N=1.752 Rs=0.568 Bv=100 Ibv=100u
+  Cjo=4p Vj=0.7 M=0.4 Tt=6n)

* ================================================================
* TEST A: DC Sweep (9V to 15V)
* ================================================================
V_bat_dc bat_raw 0 DC 12

* Voltage divider
R_div_high bat_raw bat_div 10k
R_div_low bat_div 0 2.2k

* Clamping
D_clamp_hi bat_div v3_bus D_1N4148
D_clamp_lo 0 bat_div D_1N4148

* Buffer
B_buf adc_raw 0 V = { V(bat_div) }
R_buf_out adc_raw adc_filt 1k

* RC filter
C_filt adc_filt 0 100n

* ADC input model
R_adc adc_filt 0 10Meg
C_adc adc_filt 0 5p

* === DC Analysis: Sweep battery from 0 to 20V ===
.dc V_bat_dc 0 20 0.1

.save V(bat_raw) V(bat_div) V(adc_filt)

.meas dc v_adc_at_9v FIND V(adc_filt) AT=9
.meas dc v_adc_at_12v FIND V(adc_filt) AT=12
.meas dc v_adc_at_14v4 FIND V(adc_filt) AT=14.4

.control
run
wrdata results/tb5_analog_battery_dc.csv V(bat_raw) V(bat_div) V(adc_filt)
.endc

.end
