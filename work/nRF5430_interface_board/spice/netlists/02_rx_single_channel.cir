* 02_rx_single_channel.cir
* nRF5430 Interface Board - Single RX (Read) Optocoupler Path
* Car diagnostic pin (12V blink-code) -> 1k resistor -> TLP521 LED -> optocoupler -> MCU GPIO
*
* When car line rests at 12V: LED on, transistor on, MCU reads LOW (~0V)
* When car blinks (pulls to GND): LED off, transistor off, MCU reads HIGH (3.3V via pull-up)

.title Single RX Channel - Blink Code Read Path

.include ../lib/tlp521_opto.lib
.include ../lib/car_diag_channel.lib

* === Power Rails ===
V_bat_car v_bat_car 0 DC 12.0
V_logic vcc 0 DC 3.3

* === Car Side: Diagnostic Channel with Blink Pattern ===
* Generate 3 blinks: 0.4s ON, 0.4s OFF each, starting at t=0.5s
* Pulse: V1=0 V2=5V delay=0.5s rise=1ms fall=1ms width=0.4s period=0.8s
V_blink blink_ctl 0 PULSE(0 5 0.5 1m 1m 0.4 0.8)

X_car diag_pin car_gnd blink_ctl CAR_DIAG_CHANNEL VBAT=12.0 R_PULL=680

* Car ground reference
V_car_gnd car_gnd 0 DC 0

* === Galvanic Isolation: RX Optocoupler ===
* 1kOhm current-limiting resistor on the car side
R_rx diag_pin opto_anode 1k

* Optocoupler: LED side on car domain, transistor side on logic domain
X_opto_rx opto_anode car_gnd coll_rx emitter_rx TLP521 CTR=1.0

* === MCU Side: GPIO Input with Pull-Up ===
* Internal pull-up resistor to 3.3V (nRF5430 GPIO pull-up ~13kOhm)
R_pullup_mcu vcc coll_rx 13k

* Emitter to logic ground
R_emitter emitter_rx 0 1m

* === Measurement Points ===
* V(diag_pin): car-side diagnostic voltage (12V idle, ~0V during blink)
* V(coll_rx): MCU GPIO input (inverted: LOW=idle, HIGH=blink)

.end
